* vellum -spice
* sheet psu1.d
* sheet psu2.d
R1 1 2 470
D1 2 0 red
.END
